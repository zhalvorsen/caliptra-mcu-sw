addrmap dma_ctrl {
    reg {
        field {
            sw = rw;
            onwrite = woclr;
            desc = "Error-related interrupts";
        } ERROR[0:0];
        field {
            sw = rw;
            onwrite = woclr;
            desc = "Event-related interrupts";
        } EVENT[1:1];
    } DMA_INTERRUPT_STATE @ 0x00;
    reg {
        field {
            sw = rw;
            desc = "Enable error interrupt";
        } ERROR[0:0];
        field {
            sw = rw;
            desc = "Enable event interrupt";
        } EVENT[1:1];
    } DMA_INTERRUPT_ENABLE @ 0x04;

    reg {
        field {
            sw = rw;
            desc = "Transfer size";
        } XFER_SIZE[31:0];
    } XFER_SIZE @ 0x08;

    reg {
        field {
            sw = rw;
            desc = "The higher 32-bit address of the source address";
        } SOURCE_ADDR_HIGH[31: 0];
    } SOURCE_ADDR_HIGH @ 0x0C;

    reg {
        field {
            sw = rw;
            desc = "The lower 32-bit address of the source address";
        } SOURCE_ADDR_LOWER[31: 0];
    } SOURCE_ADDR_LOWER @ 0x10;

        reg {
        field {
            sw = rw;
            desc = "The higher 32-bit address of the source address";
        } DEST_ADDR_HIGH[31: 0];
    } DEST_ADDR_HIGH @ 0x14;

    reg {
        field {
            sw = rw;
            desc = "The lower 32-bit address of the source address";
        } DEST_ADDR_LOWER[31: 0];
    } DEST_ADDR_LOWER @ 0x18;

    reg {
        field {
            sw = rw;
            desc = "Start the operation";
        } START[0:0];
    } DMA_CONTROL @ 0x1C;

    reg {
        field {
            sw = rw;
            // TODO: May extend the status
            desc = "DMA operation error. Set by HW, cleared by SW .
                    \"0\" = Read Error , \"1\" = Write Error";
        } ERR[3:1];
        field {
            sw = rw;
            desc = "DMA operation done. Set by HW, cleared by SW";
        } DONE[0:0];
    } DMA_OP_STATUS @ 0x20;

};